*******************************************************************************
*                                                                             *
* Copyright 2023 IHP PDK Authors                                              *
*                                                                             *
* Licensed under the Apache License, Version 2.0 (the "License");             *
* you may not use this file except in compliance with the License.            *
* You may obtain a copy of the License at                                     *
*                                                                             *
*     https://www.apache.org/licenses/LICENSE-2.0                             *
*                                                                             *
* Unless required by applicable law or agreed to in writing, software         *
* distributed under the License is distributed on an "AS IS" BASIS,           *
* WITHOUT WARRANTIES OR CONDITIONS OF ANY KIND, either express or implied.    *
* See the License for the specific language governing permissions and         *
* limitations under the License.                                              *
*                                                                             *
*******************************************************************************

*******************************************************************************
.model cmim_core C (TC1=3.6E-6 TC2=2E-9 TNOM=27 CJ=cap_carea CJSW=40E-18)

* subcircuit for cmim
* Note: top/bottom plate parasitic capacitance is included by parasiticC extraction!
* Note: top (Metal3) corresponds to PLUS pin
*
.subckt cap_cmim PLUS MINUS
.param l=7u
.param w=7u
.param mm_ok=0
.param sf=1E-6
.param ic=1E10
R1 PLUS 1 r=55m
.if (ic>1E9)
  C1 1 MINUS cmim_core l=l/sf w=w/sf scale=1
.else
  C1 1 MINUS cmim_core l=l/sf w=w/sf ic=ic scale=1
.endif
.ends cap_cmim
